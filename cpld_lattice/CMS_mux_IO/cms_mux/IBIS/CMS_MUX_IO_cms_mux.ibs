| IBIS Models Generator: Lattice Diamond (64-bit) 3.13.0.56.2
| Generate date: Wed Jun 26 12:07:28 2024
| IBIS File LibisMaker.ibs
| LibisGen v2.0.1.0, 02/25/2008, Lattice Semiconductor Corporation
| Modified by LibisMaker v2.0.1.0, 02/25/2008, Lattice Semiconductor
| North Carolina State University, ERL, 2006
[IBIS ver]   3.2
[File Name]   CMS_MUX_IO_cms_mux.ibs
[File Rev]   2.3
[Date]   Mon Aug  7 08:49:22 PDT 2023
[Source]   Lattice Semiconductor cs200fl Process
   LCMXO3L-9400C   FINAL
   Lattice Semiconductor has worked hard to ensure the
   models below are accurate and complete.  However, the
   data below was generated using simulation of the
   input/output model files for the silicon.  Therefore,
   the data below is for reference and initial design
   purposes only.
   Lattice Semiconductor grants permission to use this
   data for use in printed circuit design using this
   Lattice programmable logic device.  Other use of this
   code, including the selling or duplication of any
   portion is strictly prohibited.
|   NAMING CONVENTION
   The IBIS [Model] header is limited by the specification to a
   total of characters.  With such a set of characters available
   for naming models it becomes important to attempt to
   meaningfully encode the IO standards so they fit within the
   twenty character limit.  It would seem that twenty characters
   would provide room enough for describing IO's.  However, the
   PLD IO structure continues to grow more and more complex.  The
   complexity is making the twenty characters insuffiently
   descriptive.  In order to overcome this issue the naming
   convention described below is implemented to resolve the issue.
The twenty character space is managed as follows:
   bbbvvvsdddprugtcoixx
   b = standard
   v = voltage (x.xx V)
   s = slew code
   d = drive (xx.x ma)
   p = pullup code
   r = series resistance  or bank_vccio code
   u = terminate to vcc code
   g = terminate to gnd code
   t = terminate to vtt code
   c = common mode termination mode
   o = diff resistor code
   i = diff resistor current code
   x = reserved
   standard
   LVCMOS   lvc
   lvcmosd   lvd
   lvcmosr   lvr
   LVDS25E   lve
   LVTTL   lvt
   lvttld   ltd
   PCI   pci
   pcix   pcx
   lvds25   lvs
   blvds25   blv
   blvds25e   blv
   mlvds25   mlv
   mlvds25e   mlv
   lvpecl33   lvp
   lvpecl33e   lvp
   cml   cml
   hypt   hyp
   rsds25   rsd
   rsds25e   rse
   mipi_lp   mip
   mipi   mip
   vref1   vr1
   vref2   vr2
   ref_res   rer
   slew
   na   a
   fast   f
   slow   s
   pullmode
   off   a
   pullup   b
   pulldown   c
   bushold   d
   clamp   e
   up_clamp   f
   down_clamp   g
   keeper_clamp   h
   impedance or Bank_vccio
   off   a
   25   b
   33   c
   50   d
   100   e
   3.3   f
   2.5   g
   1.8   h
   1.5   i
   1.2   j
   termVCC
   off   a
   50   b
   100   c
   120   d
   termGND
   off   a
   50   b
   100   c
   120   d
   termVTT
   off   a
   60   b
   75   c
   120   d
   150   e
   210   f
   VCMT
   off   a
   VCMT   b
   VTT   c
   DDR-2   d
   differential resistor
   off   a
   100   b
   diff drive
   NA   a
   2.0   b
   3.5   c
   1.25   f
   2.5   g
   Reserved   IO type
   in   input only
   ou   output
   io   I/O
   od   Open drain
   on   Inverting differential I/O
   (signal name only)
   op   Non-Inverting differential I/O
   (signal name only)
   Lattice Semiconductor Corporation
   5555 NE Moore Court
   Hillsboro, OR 97214
   U.S.A
   TEL: 1-800-Lattice (USA and Canada)
   408-826-6000 (other locations)
   web: http://www.latticesemi.com/
   email: techsupport@latticesemi.com
[Disclaimer] This IBIS source code is intended as a design reference
   which illustrates how the Lattice Semiconductor device operates.
   It is the user's responsibility to verify their design for
   consistency and functionality through the use of formal
   verification methods.  Lattice Semiconductor provides no warranty
   regarding the use or functionality of this data.
[Copyright]   Copyright 2007 by Lattice Semiconductor Corporation
|   Component XO3L
[Component]   XO3L
[Manufacturer]   Lattice Semiconductor Corp.
[Package]
|CABGA484
| variable   typ   min   max
R_pkg   250.9m   149.0m   365.6m
L_pkg   5.27nH   2.37nH   8.84nH
C_pkg   0.63pF   0.27pF   1.05pF
[Pin] signal_name   model_name   R_pin   L_pin   C_pin
B11   CPLD_ADC_ADCLK_o_p   lvs250axxxaaaaaaacou
B9   CPLD_ADC_LCLK_o_p   lvs250axxxaaaaaaacou
A13   CPLD_ADC_ch_o_p[0]   lvs250axxxaaaaaaacou
G12   CPLD_ADC_ch_o_p[1]   lvs250axxxaaaaaaacou
A14   CPLD_ADC_ch_o_p[2]   lvs250axxxaaaaaaacou
B3   CPLD_ADC_ch_o_p[3]   lvs250axxxaaaaaaacou
B8   CPLD_ADC_ch_o_p[4]   lvs250axxxaaaaaaacou
B6   CPLD_ADC_ch_o_p[5]   lvs250axxxaaaaaaacou
B5   CPLD_ADC_ch_o_p[6]   lvs250axxxaaaaaaacou
B4   CPLD_ADC_ch_o_p[7]   lvs250axxxaaaaaaacou
W18   CSR_CS_CPLD   lvc250s080caaaaaaaou
Y19   CSR_CS_SOM   lvc250axxxggaaaaaain
U13   CSR_MISO   lvc250s080caaaaaaaou
V13   CSR_MOSI   lvc250axxxggaaaaaain
T13   CSR_SCLK_P   lvs250axxxagaaaaaain
N2   DRS4_i_A[0]   lvc250axxxggaaaaaain
M1   DRS4_i_A[1]   lvc250axxxggaaaaaain
M2   DRS4_i_A[2]   lvc250axxxggaaaaaain
L1   DRS4_i_A[3]   lvc250axxxggaaaaaain
B2   DRS4_i_refclk_p   lvs250axxxagaaaaaain
Y4   Mezz1_ADC_ch_i_p[0]  lvs250axxxagaaaabain
AA5   Mezz1_ADC_ch_i_p[1]  lvs250axxxagaaaabain
Y5   Mezz1_ADC_ch_i_p[2]  lvs250axxxagaaaabain
AA6   Mezz1_ADC_ch_i_p[3]  lvs250axxxagaaaabain
W6   Mezz1_ADC_ch_i_p[4]  lvs250axxxagaaaabain
AA7   Mezz1_ADC_ch_i_p[5]  lvs250axxxagaaaabain
AA8   Mezz1_ADC_ch_i_p[6]  lvs250axxxagaaaabain
Y8   Mezz1_ADC_ch_i_p[7]  lvs250axxxagaaaabain
R2   Mezz1_DRS4_o_A[0]   lvc250s080caaaaaaaou
P1   Mezz1_DRS4_o_A[1]   lvc250s080caaaaaaaou
N1   Mezz1_DRS4_o_A[2]   lvc250s080caaaaaaaou
P2   Mezz1_DRS4_o_A[3]   lvc250s080caaaaaaaou
T10   Mezz2_ADC_ch_i_p[0]  lvs250axxxagaaaabain
T9   Mezz2_ADC_ch_i_p[1]  lvs250axxxagaaaabain
U7   Mezz2_ADC_ch_i_p[2]  lvs250axxxagaaaabain
V8   Mezz2_ADC_ch_i_p[3]  lvs250axxxagaaaabain
V6   Mezz2_ADC_ch_i_p[4]  lvs250axxxagaaaabain
AA2   Mezz2_ADC_ch_i_p[5]  lvs250axxxagaaaabain
AA3   Mezz2_ADC_ch_i_p[6]  lvs250axxxagaaaabain
AA4   Mezz2_ADC_ch_i_p[7]  lvs250axxxagaaaabain
U1   Mezz2_DRS4_o_A[0]   lvc250s080caaaaaaaou
T3   Mezz2_DRS4_o_A[1]   lvc250s080caaaaaaaou
T2   Mezz2_DRS4_o_A[2]   lvc250s080caaaaaaaou
T1   Mezz2_DRS4_o_A[3]   lvc250s080caaaaaaaou
Y17   Mezz3_ADC_ch_i_p[0]  lvs250axxxagaaaabain
AB18   Mezz3_ADC_ch_i_p[1]  lvs250axxxagaaaabain
Y18   Mezz3_ADC_ch_i_p[2]  lvs250axxxagaaaabain
AB19   Mezz3_ADC_ch_i_p[3]  lvs250axxxagaaaabain
AB20   Mezz3_ADC_ch_i_p[4]  lvs250axxxagaaaabain
V15   Mezz3_ADC_ch_i_p[5]  lvs250axxxagaaaabain
V17   Mezz3_ADC_ch_i_p[6]  lvs250axxxagaaaabain
U14   Mezz3_ADC_ch_i_p[7]  lvs250axxxagaaaabain
D2   Mezz3_DRS4_o_A[0]   lvc250s080caaaaaaaou
D1   Mezz3_DRS4_o_A[1]   lvc250s080caaaaaaaou
C1   Mezz3_DRS4_o_A[2]   lvc250s080caaaaaaaou
D3   Mezz3_DRS4_o_A[3]   lvc250s080caaaaaaaou
Y12   Mezz4_ADC_ch_i_p[0]  lvs250axxxagaaaabain
AB14   Mezz4_ADC_ch_i_p[1]  lvs250axxxagaaaabain
Y13   Mezz4_ADC_ch_i_p[2]  lvs250axxxagaaaabain
AB15   Mezz4_ADC_ch_i_p[3]  lvs250axxxagaaaabain
Y14   Mezz4_ADC_ch_i_p[4]  lvs250axxxagaaaabain
AB16   Mezz4_ADC_ch_i_p[5]  lvs250axxxagaaaabain
Y15   Mezz4_ADC_ch_i_p[6]  lvs250axxxagaaaabain
AB17   Mezz4_ADC_ch_i_p[7]  lvs250axxxagaaaabain
G1   Mezz4_DRS4_o_A[0]   lvc250s080caaaaaaaou
G2   Mezz4_DRS4_o_A[1]   lvc250s080caaaaaaaou
E2   Mezz4_DRS4_o_A[2]   lvc250s080caaaaaaaou
F1   Mezz4_DRS4_o_A[3]   lvc250s080caaaaaaaou
AA9   Mezz5_ADC_ch_i_p[0]  lvs250axxxagaaaabain
V9   Mezz5_ADC_ch_i_p[1]  lvs250axxxagaaaabain
Y9   Mezz5_ADC_ch_i_p[2]  lvs250axxxagaaaabain
V10   Mezz5_ADC_ch_i_p[3]  lvs250axxxagaaaabain
AA11   Mezz5_ADC_ch_i_p[4]  lvs250axxxagaaaabain
T11   Mezz5_ADC_ch_i_p[5]  lvs250axxxagaaaabain
AB12   Mezz5_ADC_ch_i_p[6]  lvs250axxxagaaaabain
V11   Mezz5_ADC_ch_i_p[7]  lvs250axxxagaaaabain
K2   Mezz5_DRS4_o_A[0]   lvc250s080caaaaaaaou
J1   Mezz5_DRS4_o_A[1]   lvc250s080caaaaaaaou
H1   Mezz5_DRS4_o_A[2]   lvc250s080caaaaaaaou
J2   Mezz5_DRS4_o_A[3]   lvc250s080caaaaaaaou
P19   Mezz_ADC_ADCLK_p[0]  lvs250axxxagaaaaaain
M16   Mezz_ADC_ADCLK_p[1]  lvs250axxxagaaaaaain
M20   Mezz_ADC_ADCLK_p[2]  lvs250axxxagaaaaaain
P22   Mezz_ADC_ADCLK_p[3]  lvs250axxxagaaaaaain
T22   Mezz_ADC_ADCLK_p[4]  lvs250axxxagaaaaaain
N20   Mezz_ADC_LCLK_p[0]   lvs250axxxagaaaaaain
N17   Mezz_ADC_LCLK_p[1]   lvs250axxxagaaaaaain
P17   Mezz_ADC_LCLK_p[2]   lvs250axxxagaaaaaain
N22   Mezz_ADC_LCLK_p[3]   lvs250axxxagaaaaaain
R22   Mezz_ADC_LCLK_p[4]   lvs250axxxagaaaaaain
A16   Mezz_DRS4_o_refclk_p[0] lvs250axxxaaaaaaacou
A15   Mezz_DRS4_o_refclk_p[1] lvs250axxxaaaaaaacou
A19   Mezz_DRS4_o_refclk_p[2] lvs250axxxaaaaaaacou
A18   Mezz_DRS4_o_refclk_p[3] lvs250axxxaaaaaaacou
A17   Mezz_DRS4_o_refclk_p[4] lvs250axxxaaaaaaacou
E13   Mux_sel[0]   lvc250axxxggaaaaaain
D13   Mux_sel[1]   lvc250axxxggaaaaaain
C13   Mux_sel[2]   lvc250axxxggaaaaaain
D11   o_Mezz_ADC_DAC_nReset[0] lvc250s080caaaaaaaou
AA13   o_Mezz_ADC_DAC_nReset[1] lvc250s080caaaaaaaou
AB13   o_Mezz_ADC_DAC_nReset[2] lvc250s080caaaaaaaou
AA10   o_Mezz_ADC_DAC_nReset[3] lvc250s080caaaaaaaou
E10   o_Mezz_ADC_DAC_nReset[4] lvc250s080caaaaaaaou
H18   o_Mezz_ADC_nCS[0]   lvc250s080caaaaaaaou
W1   o_Mezz_ADC_nCS[1]   lvc250s080caaaaaaaou
L22   o_Mezz_ADC_nCS[2]   lvc250s080caaaaaaaou
H22   o_Mezz_ADC_nCS[3]   lvc250s080caaaaaaaou
D21   o_Mezz_ADC_nCS[4]   lvc250s080caaaaaaaou
F18   o_Mezz_DAC_sel0[0]   lvc250s080caaaaaaaou
Y2   o_Mezz_DAC_sel0[1]   lvc250s080caaaaaaaou
L21   o_Mezz_DAC_sel0[2]   lvc250s080caaaaaaaou
H21   o_Mezz_DAC_sel0[3]   lvc250s080caaaaaaaou
C22   o_Mezz_DAC_sel0[4]   lvc250s080caaaaaaaou
F19   o_Mezz_DAC_sel1[0]   lvc250s080caaaaaaaou
AA1   o_Mezz_DAC_sel1[1]   lvc250s080caaaaaaaou
L20   o_Mezz_DAC_sel1[2]   lvc250s080caaaaaaaou
G22   o_Mezz_DAC_sel1[3]   lvc250s080caaaaaaaou
C21   o_Mezz_DAC_sel1[4]   lvc250s080caaaaaaaou
H17   o_Mezz_DRS4_o_denable[0] lvc250s080caaaaaaaou
H16   o_Mezz_DRS4_o_denable[1] lvc250s080caaaaaaaou
Y22   o_Mezz_DRS4_o_denable[2] lvc250s080caaaaaaaou
J22   o_Mezz_DRS4_o_denable[3] lvc250s080caaaaaaaou
G20   o_Mezz_DRS4_o_denable[4] lvc250s080caaaaaaaou
D19   o_Mezz_Mux0[0]   lvc250s080caaaaaaaou
J17   o_Mezz_Mux0[1]   lvc250s080caaaaaaaou
Y20   o_Mezz_Mux0[2]   lvc250s080caaaaaaaou
K19   o_Mezz_Mux0[3]   lvc250s080caaaaaaaou
F22   o_Mezz_Mux0[4]   lvc250s080caaaaaaaou
D20   o_Mezz_Mux1[0]   lvc250s080caaaaaaaou
F17   o_Mezz_Mux1[1]   lvc250s080caaaaaaaou
AA22   o_Mezz_Mux1[2]   lvc250s080caaaaaaaou
K22   o_Mezz_Mux1[3]   lvc250s080caaaaaaaou
G21   o_Mezz_Mux1[4]   lvc250s080caaaaaaaou
R3   o_Mezz_Mux_gain_0[0] lvc250s080caaaaaaaou
G17   o_Mezz_Mux_gain_0[1] lvc250s080caaaaaaaou
N4   o_Mezz_Mux_gain_0[2] lvc250s080caaaaaaaou
L4   o_Mezz_Mux_gain_0[3] lvc250s080caaaaaaaou
H3   o_Mezz_Mux_gain_0[4] lvc250s080caaaaaaaou
R4   o_Mezz_Mux_gain_1[0] lvc250s080caaaaaaaou
E19   o_Mezz_Mux_gain_1[1] lvc250s080caaaaaaaou
N5   o_Mezz_Mux_gain_1[2] lvc250s080caaaaaaaou
L3   o_Mezz_Mux_gain_1[3] lvc250s080caaaaaaaou
K5   o_Mezz_Mux_gain_1[4] lvc250s080caaaaaaaou
H20   o_Mezz_nSHDN[0]   lvc250s080caaaaaaaou
W3   o_Mezz_nSHDN[1]   lvc250s080caaaaaaaou
W22   o_Mezz_nSHDN[2]   lvc250s080caaaaaaaou
J19   o_Mezz_nSHDN[3]   lvc250s080caaaaaaaou
E21   o_Mezz_nSHDN[4]   lvc250s080caaaaaaaou
U12   o_Mezz_tcal_en[0]   lvc250s080caaaaaaaou
V12   o_Mezz_tcal_en[1]   lvc250s080caaaaaaaou
AB10   o_Mezz_tcal_en[2]   lvc250s080caaaaaaaou
A10   o_Mezz_tcal_en[3]   lvc250s080caaaaaaaou
F10   o_Mezz_tcal_en[4]   lvc250s080caaaaaaaou
| Models and submodels in the file (5): lvc250axxxggaaaaaain (Input), lvc250s080caaaaaaaou (Output), lvs250axxxaaaaaaacou (Output), lvs250axxxagaaaaaain (Input), lvs250axxxagaaaabain (Input)
